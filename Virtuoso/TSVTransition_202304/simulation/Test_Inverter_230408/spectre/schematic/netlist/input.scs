// Design: TransitionSimu_MISModel/Test_Inverter_230408
simulator lang=spectre
global 0
include "/eda/home/wc/Projects/Virtuoso/TSV_Transition_Simu/TSV_Transition_202304/TSMC-65nm(OA)/PDK_files/tsmcN65/../models/spectre/toplevel.scs" section=tt_lib

// tsmcN65/inv/schematic
subckt inv G Gb IN OUT P Pb
parameters pl=60n pw=200n pf=1 psd=200n psa=175n psb=175n nl=60n nw=200n nf=1 nsd=200n nsa=175n nsb=175n
    PM1 (OUT IN P Pb) pch l=pl w=pw*pf m=1 nf=pf
    NM1 (OUT IN G Gb) nch l=nl w=nw*nf m=1 nf=nf
ends inv

// TransitionSimu_MISModel/Test_Inverter_230408/schematic
I0 (0 0 net1 net2 net5 net5) inv m=1 pl=60n pw=400n pf=1 psd=200n psa=175.00n psb=175.00n nl=60n nw=200n nf=1 nsd=200n nsa=175.00n nsb=175.00n
V1 (net5 0) vsource dc=1.2 type=dc
V0 (net1 0) vsource dc=1 type=pulse val0=0 val1=1.2 period=1n delay=1n rise=50p fall=50p
C0 (net2 0) capacitor c=2f
simulatorOptions options temp=27
tran tran stop=6n errpreset=moderate
