// Generated for: spectre
// Generated on: Apr 10 20:40:14 2023
// Design library name: TransitionSimu_MISModel
// Design cell name: MISModel_TransitionSimu_230410
// Design view name: schematic
simulator lang=spectre
global 0
include "/eda/home/wc/Projects/Virtuoso/TSV_Transition_Simu/TSV_Transition_202304/TSMC-65nm(OA)/PDK_files/tsmcN65/../models/spectre/toplevel.scs" section=tt_lib

// Library name: TransitionSimu_MISModel
// Cell name: MISModel_AdjacentXtalk
// View name: schematic
subckt MISModel_AdjacentXtalk port_a port_b
    C0 (port_a port_b) capacitor c=12.0f
    R0 (port_a port_b) resistor r=100
ends MISModel_AdjacentXtalk
// End of subcircuit definition.

// Library name: TransitionSimu_MISModel
// Cell name: MISModel_Aggressor
// View name: schematic
subckt MISModel_Aggressor tsv_coupling tsv_in tsv_out
    R1 (net09 tsv_out) resistor r=1u
    R0 (net07 tsv_coupling) resistor r=1u
    C0 (tsv_coupling 0) capacitor c=2.1f
    L1 (tsv_coupling net09) inductor l=5p
    L0 (tsv_in net07) inductor l=5p
ends MISModel_Aggressor
// End of subcircuit definition.

// Library name: TransitionSimu_MISModel
// Cell name: MISModel_DiagonalXtalk
// View name: schematic
subckt MISModel_DiagonalXtalk port_a port_b
    R0 (port_a port_b) resistor r=400
    C0 (port_a port_b) capacitor c=3f
ends MISModel_DiagonalXtalk
// End of subcircuit definition.

// Library name: TransitionSimu_MISModel
// Cell name: MISModel_TransitionSimu_230410
// View name: schematic
V170 (net01127 0) vsource dc=1.2 type=pulse val0=0 val1=1.2 period=2n \
        rise=50p fall=50p
V169 (net01361 0) vsource dc=1.2 type=pulse val0=1.2 val1=0 period=2n \
        rise=50p fall=50p
V168 (net01367 0) vsource dc=1.2 type=pulse val0=0 val1=1.2 period=2n \
        rise=50p fall=50p
V167 (net01100 0) vsource dc=1.2 type=pulse val0=0 val1=1.2 period=2n \
        rise=50p fall=50p
V166 (net01323 0) vsource dc=1.2 type=pulse val0=1.2 val1=0 period=2n \
        rise=50p fall=50p
V165 (net01369 0) vsource dc=1.2 type=pulse val0=1.2 val1=0 period=2n \
        rise=50p fall=50p
V164 (net01363 0) vsource dc=1.2 type=pulse val0=1.2 val1=0 period=2n \
        rise=50p fall=50p
V163 (net01093 0) vsource dc=1.2 type=pulse val0=1.2 val1=0 period=2n \
        rise=50p fall=50p
V162 (net01268 0) vsource dc=1.2 type=pulse val0=1.2 val1=0 period=2n \
        rise=50p fall=50p
V161 (net01256 0) vsource dc=1.2 type=pulse val0=1.2 val1=0 period=2n \
        rise=50p fall=50p
V160 (net01063 0) vsource dc=1.2 type=pulse val0=1.2 val1=0 period=2n \
        rise=50p fall=50p
V159 (net01292 0) vsource dc=1.2 type=pulse val0=0 val1=1.2 period=2n \
        rise=50p fall=50p
V158 (net01275 0) vsource dc=1.2 type=pulse val0=0 val1=1.2 period=2n \
        rise=50p fall=50p
V157 (net01280 0) vsource dc=1.2 type=pulse val0=1.2 val1=0 period=2n \
        rise=50p fall=50p
V156 (net01358 0) vsource dc=1.2 type=pulse val0=0 val1=1.2 period=2n \
        rise=50p fall=50p
V155 (net01095 0) vsource dc=1.2 type=pulse val0=0 val1=1.2 period=2n \
        rise=50p fall=50p
V154 (net01244 0) vsource dc=1.2 type=pulse val0=1.2 val1=0 period=2n \
        rise=50p fall=50p
V153 (net01353 0) vsource dc=1.2 type=pulse val0=1.2 val1=0 period=2n \
        rise=50p fall=50p
V152 (net0965 0) vsource dc=1.2 type=pulse val0=1.2 val1=0 period=2n \
        rise=50p fall=50p
V151 (net0984 0) vsource dc=1.2 type=pulse val0=1.2 val1=0 period=2n \
        rise=50p fall=50p
V150 (net01061 0) vsource dc=1.2 type=pulse val0=1.2 val1=0 period=2n \
        rise=50p fall=50p
V149 (net01113 0) vsource dc=1.2 type=pulse val0=1.2 val1=0 period=2n \
        rise=50p fall=50p
V148 (net01134 0) vsource dc=1.2 type=pulse val0=1.2 val1=0 period=2n \
        rise=50p fall=50p
V147 (net01166 0) vsource dc=1.2 type=pulse val0=0 val1=1.2 period=2n \
        rise=50p fall=50p
V146 (net01150 0) vsource dc=1.2 type=pulse val0=0 val1=1.2 period=2n \
        rise=50p fall=50p
V145 (net01143 0) vsource dc=1.2 type=pulse val0=1.2 val1=0 period=2n \
        rise=50p fall=50p
V144 (net01168 0) vsource dc=1.2 type=pulse val0=0 val1=1.2 period=2n \
        rise=50p fall=50p
V143 (net01155 0) vsource dc=1.2 type=pulse val0=1.2 val1=0 period=2n \
        rise=50p fall=50p
V142 (net01196 0) vsource dc=1.2 type=pulse val0=0 val1=1.2 period=2n \
        rise=50p fall=50p
V141 (net01195 0) vsource dc=1.2 type=pulse val0=0 val1=1.2 period=2n \
        rise=50p fall=50p
V140 (net01122 0) vsource dc=1.2 type=pulse val0=0 val1=1.2 period=2n \
        rise=50p fall=50p
V139 (net01193 0) vsource dc=1.2 type=pulse val0=0 val1=1.2 period=2n \
        rise=50p fall=50p
V138 (net01169 0) vsource dc=1.2 type=pulse val0=1.2 val1=0 period=2n \
        rise=50p fall=50p
V137 (net01141 0) vsource dc=1.2 type=pulse val0=1.2 val1=0 period=2n \
        rise=50p fall=50p
V136 (net01000 0) vsource dc=1.2 type=pulse val0=1.2 val1=0 period=2n \
        rise=50p fall=50p
V135 (net0978 0) vsource dc=1.2 type=pulse val0=1.2 val1=0 period=2n \
        rise=50p fall=50p
V134 (net0898 0) vsource dc=1.2 type=pulse val0=0 val1=1.2 period=2n \
        rise=50p fall=50p
V133 (net0807 0) vsource dc=1.2 type=pulse val0=0 val1=1.2 period=2n \
        rise=50p fall=50p
V132 (net0867 0) vsource dc=1.2 type=pulse val0=0 val1=1.2 period=2n \
        rise=50p fall=50p
V131 (net0871 0) vsource dc=1.2 type=pulse val0=0 val1=1.2 period=2n \
        rise=50p fall=50p
V130 (net0961 0) vsource dc=1.2 type=pulse val0=0 val1=1.2 period=2n \
        rise=50p fall=50p
V129 (net0906 0) vsource dc=1.2 type=pulse val0=0 val1=1.2 period=2n \
        rise=50p fall=50p
V128 (net0856 0) vsource dc=1.2 type=pulse val0=0 val1=1.2 period=2n \
        rise=50p fall=50p
V127 (net0892 0) vsource dc=1.2 type=pulse val0=0 val1=1.2 period=2n \
        rise=50p fall=50p
V126 (net0905 0) vsource dc=1.2 type=pulse val0=0 val1=1.2 period=2n \
        rise=50p fall=50p
V125 (net0103 0) vsource dc=1.2 type=pulse val0=0 val1=1.2 period=2n \
        rise=50p fall=50p
V124 (net0110 0) vsource dc=1.2 type=pulse val0=1.2 val1=0 period=2n \
        rise=50p fall=50p
V123 (net0897 0) vsource dc=1.2 type=pulse val0=1.2 val1=0 period=2n \
        rise=50p fall=50p
V122 (net0860 0) vsource dc=1.2 type=pulse val0=1.2 val1=0 period=2n \
        rise=50p fall=50p
V121 (net0959 0) vsource dc=1.2 type=pulse val0=1.2 val1=0 period=2n \
        rise=50p fall=50p
V120 (net0954 0) vsource dc=1.2 type=pulse val0=0 val1=1.2 period=2n \
        rise=50p fall=50p
V119 (net0895 0) vsource dc=1.2 type=pulse val0=0 val1=1.2 period=2n \
        rise=50p fall=50p
V118 (net0817 0) vsource dc=1.2 type=pulse val0=1.2 val1=0 period=2n \
        rise=50p fall=50p
V117 (net0163 0) vsource dc=1.2 type=pulse val0=1.2 val1=0 period=2n \
        rise=50p fall=50p
V116 (net0932 0) vsource dc=1.2 type=pulse val0=1.2 val1=0 period=2n \
        rise=50p fall=50p
V115 (net0928 0) vsource dc=1.2 type=pulse val0=0 val1=1.2 period=2n \
        rise=50p fall=50p
V114 (net0921 0) vsource dc=1.2 type=pulse val0=0 val1=1.2 period=2n \
        rise=50p fall=50p
V113 (net0840 0) vsource dc=1.2 type=pulse val0=0 val1=1.2 period=2n \
        rise=50p fall=50p
V112 (net0835 0) vsource dc=1.2 type=pulse val0=0 val1=1.2 period=2n \
        rise=50p fall=50p
V111 (net0850 0) vsource dc=1.2 type=pulse val0=1.2 val1=0 period=2n \
        rise=50p fall=50p
V110 (net0930 0) vsource dc=1.2 type=pulse val0=1.2 val1=0 period=2n \
        rise=50p fall=50p
V109 (net0957 0) vsource dc=1.2 type=pulse val0=1.2 val1=0 period=2n \
        rise=50p fall=50p
V108 (net0929 0) vsource dc=1.2 type=pulse val0=1.2 val1=0 period=2n \
        rise=50p fall=50p
V97 (net0229 0) vsource dc=1.2 type=pulse val0=0 val1=1.2 period=2n \
        rise=50p fall=50p
V96 (net0236 0) vsource dc=1.2 type=pulse val0=0 val1=1.2 period=2n \
        rise=50p fall=50p
V95 (net0917 0) vsource dc=1.2 type=pulse val0=0 val1=1.2 period=2n \
        rise=50p fall=50p
V94 (net0910 0) vsource dc=1.2 type=pulse val0=0 val1=1.2 period=2n \
        rise=50p fall=50p
V93 (net0908 0) vsource dc=1.2 type=pulse val0=0 val1=1.2 period=2n \
        rise=50p fall=50p
V92 (net0899 0) vsource dc=1.2 type=pulse val0=0 val1=1.2 period=2n \
        rise=50p fall=50p
V91 (net0273 0) vsource dc=1.2 type=pulse val0=0 val1=1.2 period=2n \
        rise=50p fall=50p
V90 (net0280 0) vsource dc=1.2 type=pulse val0=0 val1=1.2 period=2n \
        rise=50p fall=50p
V89 (net0287 0) vsource dc=1.2 type=pulse val0=0 val1=1.2 period=2n \
        rise=50p fall=50p
V84 (net0292 0) vsource dc=1.2 type=pulse val0=0 val1=1.2 period=2n \
        rise=50p fall=50p
V83 (net0299 0) vsource dc=1.2 type=pulse val0=1.2 val1=0 period=2n \
        rise=50p fall=50p
V82 (net0314 0) vsource dc=1.2 type=pulse val0=1.2 val1=0 period=2n \
        rise=50p fall=50p
V81 (net0317 0) vsource dc=1.2 type=pulse val0=1.2 val1=0 period=2n \
        rise=50p fall=50p
V80 (net0301 0) vsource dc=1.2 type=pulse val0=1.2 val1=0 period=2n \
        rise=50p fall=50p
V79 (net0327 0) vsource dc=1.2 type=pulse val0=0 val1=1.2 period=2n \
        rise=50p fall=50p
V78 (net0334 0) vsource dc=1.2 type=pulse val0=0 val1=1.2 period=2n \
        rise=50p fall=50p
V77 (net0349 0) vsource dc=1.2 type=pulse val0=1.2 val1=0 period=2n \
        rise=50p fall=50p
V76 (net0352 0) vsource dc=1.2 type=pulse val0=1.2 val1=0 period=2n \
        rise=50p fall=50p
V75 (net0336 0) vsource dc=1.2 type=pulse val0=1.2 val1=0 period=2n \
        rise=50p fall=50p
V74 (net0364 0) vsource dc=1.2 type=pulse val0=0 val1=1.2 period=2n \
        rise=50p fall=50p
V73 (net0371 0) vsource dc=1.2 type=pulse val0=0 val1=1.2 period=2n \
        rise=50p fall=50p
V72 (net0378 0) vsource dc=1.2 type=pulse val0=0 val1=1.2 period=2n \
        rise=50p fall=50p
V71 (net0385 0) vsource dc=1.2 type=pulse val0=0 val1=1.2 period=2n \
        rise=50p fall=50p
V70 (net0392 0) vsource dc=1.2 type=pulse val0=1.2 val1=0 period=2n \
        rise=50p fall=50p
V69 (net0793 0) vsource dc=1.2 type=pulse val0=1.2 val1=0 period=2n \
        rise=50p fall=50p
V68 (net0938 0) vsource dc=1.2 type=pulse val0=1.2 val1=0 period=2n \
        rise=50p fall=50p
V67 (net0890 0) vsource dc=1.2 type=pulse val0=1.2 val1=0 period=2n \
        rise=50p fall=50p
V53 (net0446 0) vsource dc=1.2 type=pulse val0=1.2 val1=0 period=2n \
        rise=50p fall=50p
V52 (net0413 0) vsource dc=1.2 type=pulse val0=1.2 val1=0 period=2n \
        rise=50p fall=50p
V51 (net0405 0) vsource dc=1.2 type=pulse val0=1.2 val1=0 period=2n \
        rise=50p fall=50p
V50 (net0424 0) vsource dc=1.2 type=pulse val0=1.2 val1=0 period=2n \
        rise=50p fall=50p
V49 (net0397 0) vsource dc=1.2 type=pulse val0=1.2 val1=0 period=2n \
        rise=50p fall=50p
V48 (net0441 0) vsource dc=1.2 type=pulse val0=1.2 val1=0 period=2n \
        rise=50p fall=50p
V47 (net0421 0) vsource dc=1.2 type=pulse val0=1.2 val1=0 period=2n \
        rise=50p fall=50p
V46 (net0415 0) vsource dc=1.2 type=pulse val0=1.2 val1=0 period=2n \
        rise=50p fall=50p
V45 (net082 0) vsource dc=1.2 type=pulse val0=1.2 val1=0 period=2n \
        rise=50p fall=50p
V44 (net0432 0) vsource dc=1.2 type=pulse val0=1.2 val1=0 period=2n \
        rise=50p fall=50p
V43 (net094 0) vsource dc=1.2 type=pulse val0=1.2 val1=0 period=2n \
        rise=50p fall=50p
V42 (net0101 0) vsource dc=1.2 type=pulse val0=1.2 val1=0 period=2n \
        rise=50p fall=50p
V41 (net0108 0) vsource dc=1.2 type=pulse val0=1.2 val1=0 period=2n \
        rise=50p fall=50p
V40 (net0115 0) vsource dc=1.2 type=pulse val0=1.2 val1=0 period=2n \
        rise=50p fall=50p
V39 (net0122 0) vsource dc=1.2 type=pulse val0=1.2 val1=0 period=2n \
        rise=50p fall=50p
V38 (net0129 0) vsource dc=1.2 type=pulse val0=1.2 val1=0 period=2n \
        rise=50p fall=50p
V37 (net0136 0) vsource dc=1.2 type=pulse val0=1.2 val1=0 period=2n \
        rise=50p fall=50p
V36 (net0143 0) vsource dc=1.2 type=pulse val0=1.2 val1=0 period=2n \
        rise=50p fall=50p
V35 (net0448 0) vsource dc=1.2 type=pulse val0=1.2 val1=0 period=2n \
        rise=50p fall=50p
V34 (net0436 0) vsource dc=1.2 type=pulse val0=0 val1=1.2 period=2n \
        rise=50p fall=50p
V33 (net0170 0) vsource dc=1.2 type=pulse val0=0 val1=1.2 period=2n \
        rise=50p fall=50p
V32 (net0173 0) vsource dc=1.2 type=pulse val0=0 val1=1.2 period=2n \
        rise=50p fall=50p
V31 (net0425 0) vsource dc=1.2 type=pulse val0=0 val1=1.2 period=2n \
        rise=50p fall=50p
V30 (net0183 0) vsource dc=1.2 type=pulse val0=1.2 val1=0 period=2n \
        rise=50p fall=50p
V29 (net0190 0) vsource dc=1.2 type=pulse val0=1.2 val1=0 period=2n \
        rise=50p fall=50p
V28 (net0205 0) vsource dc=1.2 type=pulse val0=0 val1=1.2 period=2n \
        rise=50p fall=50p
V27 (net0208 0) vsource dc=1.2 type=pulse val0=0 val1=1.2 period=2n \
        rise=50p fall=50p
V26 (net0192 0) vsource dc=1.2 type=pulse val0=0 val1=1.2 period=2n \
        rise=50p fall=50p
V25 (net0220 0) vsource dc=1.2 type=pulse val0=1.2 val1=0 period=2n \
        rise=50p fall=50p
V24 (net0227 0) vsource dc=1.2 type=pulse val0=1.2 val1=0 period=2n \
        rise=50p fall=50p
V23 (net0234 0) vsource dc=1.2 type=pulse val0=1.2 val1=0 period=2n \
        rise=50p fall=50p
V22 (net0241 0) vsource dc=1.2 type=pulse val0=1.2 val1=0 period=2n \
        rise=50p fall=50p
V21 (net0248 0) vsource dc=1.2 type=pulse val0=0 val1=1.2 period=2n \
        rise=50p fall=50p
V20 (net0255 0) vsource dc=1.2 type=pulse val0=0 val1=1.2 period=2n \
        rise=50p fall=50p
V19 (net0262 0) vsource dc=1.2 type=pulse val0=0 val1=1.2 period=2n \
        rise=50p fall=50p
V18 (net0269 0) vsource dc=1.2 type=pulse val0=0 val1=1.2 period=2n \
        rise=50p fall=50p
V16 (net0146 0) vsource dc=1.2 type=pulse val0=1.2 val1=0 period=2n \
        rise=50p fall=50p
V15 (net017 0) vsource dc=1.2 type=pulse val0=1.2 val1=0 period=2n \
        rise=50p fall=50p
V14 (net032 0) vsource dc=1.2 type=pulse val0=0 val1=1.2 period=2n \
        rise=50p fall=50p
V13 (net035 0) vsource dc=1.2 type=pulse val0=0 val1=1.2 period=2n \
        rise=50p fall=50p
V12 (net0155 0) vsource dc=1.2 type=pulse val0=0 val1=1.2 period=2n \
        rise=50p fall=50p
V11 (net047 0) vsource dc=1.2 type=pulse val0=1.2 val1=0 period=2n \
        rise=50p fall=50p
V10 (net054 0) vsource dc=1.2 type=pulse val0=1.2 val1=0 period=2n \
        rise=50p fall=50p
V9 (net0145 0) vsource dc=1.2 type=pulse val0=1.2 val1=0 period=2n \
        rise=50p fall=50p
V8 (net0158 0) vsource dc=1.2 type=pulse val0=1.2 val1=0 period=2n \
        rise=50p fall=50p
V7 (net09 0) vsource dc=1.2 type=pulse val0=0 val1=1.2 period=2n rise=50p \
        fall=50p
V6 (net016 0) vsource dc=1.2 type=pulse val0=0 val1=1.2 period=2n rise=50p \
        fall=50p
V5 (net08 0) vsource dc=1.2 type=pulse val0=0 val1=1.2 period=2n rise=50p \
        fall=50p
V4 (net07 0) vsource dc=1.2 type=pulse val0=0 val1=1.2 period=2n rise=50p \
        fall=50p
V3 (net015 0) vsource dc=1.2 type=pulse val0=0 val1=1.2 period=2n rise=50p \
        fall=50p
V1 (net018 0) vsource dc=1.2 type=pulse val0=0 val1=1.2 period=2n rise=50p \
        fall=50p
V0 (net031 0) vsource dc=1.2 type=pulse val0=0 val1=1.2 period=2n rise=50p \
        fall=50p
V2 (net23 0) vsource dc=1.2 type=pulse val0=1.2 val1=0 period=2n rise=50p \
        fall=50p
V17 (net37 0) vsource dc=1.2 type=pulse val0=0 val1=1.2 period=2n rise=50p \
        fall=50p
R170 (net01127 net01347) resistor r=50
R169 (net01361 net01200) resistor r=50
R168 (net01367 net01342) resistor r=50
R167 (net01100 net01070) resistor r=50
R166 (net01323 net01343) resistor r=50
R165 (net01369 net01299) resistor r=50
R164 (net01363 net01187) resistor r=50
R163 (net01093 net01182) resistor r=50
R162 (net01268 net01216) resistor r=50
R161 (net01256 net01249) resistor r=50
R160 (net01063 net01165) resistor r=50
R159 (net01292 net01114) resistor r=50
R158 (net01275 net01365) resistor r=50
R157 (net01280 net01333) resistor r=50
R156 (net01358 net01137) resistor r=50
R155 (net01095 net01271) resistor r=50
R154 (net01244 net01203) resistor r=50
R153 (net01353 net01240) resistor r=50
R152 (net0965 net0963) resistor r=50
R151 (net0984 net0979) resistor r=50
R150 (net01061 net01059) resistor r=50
R149 (net01113 net01173) resistor r=50
R148 (net01134 net01160) resistor r=50
R147 (net01166 net01161) resistor r=50
R146 (net01150 net01188) resistor r=50
R145 (net01143 net01125) resistor r=50
R144 (net01168 net01079) resistor r=50
R143 (net01155 net01116) resistor r=50
R142 (net01196 net01010) resistor r=50
R141 (net01193 net01120) resistor r=50
R140 (net01195 net01036) resistor r=50
R139 (net01122 net01096) resistor r=50
R138 (net01169 net01197) resistor r=50
R137 (net01141 net01162) resistor r=50
R136 (net01000 net01099) resistor r=50
R135 (net0978 net01181) resistor r=50
R134 (net0898 net0918) resistor r=50
R133 (net0807 net0952) resistor r=50
R132 (net0961 net0907) resistor r=50
R131 (net0867 net0865) resistor r=50
R130 (net0871 net0814) resistor r=50
R129 (net0906 net0926) resistor r=50
R128 (net0856 net0937) resistor r=50
R127 (net0892 net0916) resistor r=50
R126 (net0905 net0912) resistor r=50
R125 (net0103 net0102) resistor r=50
R124 (net0110 net0109) resistor r=50
R123 (net0959 net0866) resistor r=50
R122 (net0897 net0124) resistor r=50
R121 (net0860 net0872) resistor r=50
R120 (net0954 net0949) resistor r=50
R119 (net0895 net0936) resistor r=50
R118 (net0932 net0922) resistor r=50
R117 (net0817 net0946) resistor r=50
R116 (net0163 net0164) resistor r=50
R115 (net0928 net0852) resistor r=50
R114 (net0921 net0848) resistor r=50
R113 (net0840 net0830) resistor r=50
R112 (net0835 net0843) resistor r=50
R111 (net0850 net0815) resistor r=50
R110 (net0930 net0953) resistor r=50
R109 (net0957 net0896) resistor r=50
R108 (net0929 net0903) resistor r=50
R97 (net0229 net0228) resistor r=50
R96 (net0236 net0235) resistor r=50
R95 (net0908 net0845) resistor r=50
R94 (net0917 net0250) resistor r=50
R93 (net0910 net0823) resistor r=50
R92 (net0899 net0800) resistor r=50
R91 (net0273 net0272) resistor r=50
R90 (net0280 net0279) resistor r=50
R89 (net0287 net0286) resistor r=50
R84 (net0292 net0291) resistor r=50
R83 (net0299 net0298) resistor r=50
R82 (net0301 net0302) resistor r=50
R81 (net0314 net0313) resistor r=50
R80 (net0317 net0318) resistor r=50
R79 (net0327 net0326) resistor r=50
R78 (net0334 net0333) resistor r=50
R77 (net0336 net0337) resistor r=50
R76 (net0349 net0348) resistor r=50
R75 (net0352 net0353) resistor r=50
R74 (net0364 net0363) resistor r=50
R73 (net0371 net0370) resistor r=50
R72 (net0378 net0377) resistor r=50
R71 (net0385 net0384) resistor r=50
R70 (net0392 net0391) resistor r=50
R69 (net0793 net0819) resistor r=50
R68 (net0938 net0888) resistor r=50
R67 (net0890 net0844) resistor r=50
R53 (net0446 net0409) resistor r=50
R52 (net0413 net0454) resistor r=50
R51 (net0397 net0408) resistor r=50
R50 (net0405 net0400) resistor r=50
R49 (net0424 net048) resistor r=50
R48 (net0441 net056) resistor r=50
R47 (net0421 net063) resistor r=50
R46 (net0432 net0414) resistor r=50
R45 (net0415 net0456) resistor r=50
R44 (net082 net083) resistor r=50
R43 (net094 net093) resistor r=50
R42 (net0101 net0100) resistor r=50
R41 (net0108 net0107) resistor r=50
R40 (net0115 net0114) resistor r=50
R39 (net0122 net0121) resistor r=50
R38 (net0129 net0128) resistor r=50
R37 (net0136 net0426) resistor r=50
R36 (net0143 net0443) resistor r=50
R35 (net0448 net0402) resistor r=50
R34 (net0436 net0410) resistor r=50
R33 (net0425 net0439) resistor r=50
R32 (net0170 net0169) resistor r=50
R31 (net0173 net0174) resistor r=50
R30 (net0183 net0182) resistor r=50
R29 (net0190 net0189) resistor r=50
R28 (net0192 net0193) resistor r=50
R27 (net0205 net0204) resistor r=50
R26 (net0208 net0209) resistor r=50
R25 (net0220 net0219) resistor r=50
R24 (net0227 net0226) resistor r=50
R23 (net0234 net0233) resistor r=50
R22 (net0241 net0240) resistor r=50
R21 (net0248 net0247) resistor r=50
R20 (net0255 net0254) resistor r=50
R19 (net0262 net0261) resistor r=50
R18 (net0269 net0268) resistor r=50
R17 (net0146 net0137) resistor r=50
R16 (net017 net0152) resistor r=50
R15 (net0155 net0144) resistor r=50
R14 (net032 net0133) resistor r=50
R13 (net035 net036) resistor r=50
R12 (net047 net046) resistor r=50
R11 (net054 net053) resistor r=50
R10 (net0145 net060) resistor r=50
R9 (net0158 net0142) resistor r=50
R8 (net09 net079) resistor r=50
R7 (net016 net067) resistor r=50
R6 (net08 net065) resistor r=50
R5 (net07 net06) resistor r=50
R4 (net015 net050) resistor r=50
R3 (net018 net019) resistor r=50
R2 (net031 net030) resistor r=50
R0 (net23 net22) resistor r=50
R1 (net37 net36) resistor r=50
I656 (net01357 net01345) MISModel_AdjacentXtalk
I651 (net01136 net01322) MISModel_AdjacentXtalk
I645 (net01355 net01068) MISModel_AdjacentXtalk
I641 (net01255 net01202) MISModel_AdjacentXtalk
I620 (net01351 net01232) MISModel_AdjacentXtalk
I616 (net01360 net01352) MISModel_AdjacentXtalk
I610 (net01315 net01331) MISModel_AdjacentXtalk
I605 (net01371 net01228) MISModel_AdjacentXtalk
I593 (net01102 net01049) MISModel_AdjacentXtalk
I592 (net01016 net0977) MISModel_AdjacentXtalk
I591 (net01002 net01172) MISModel_AdjacentXtalk
I590 (net01107 net01164) MISModel_AdjacentXtalk
I555 (net01119 net01006) MISModel_AdjacentXtalk
I552 (net01031 net01194) MISModel_AdjacentXtalk
I547 (net01131 net01078) MISModel_AdjacentXtalk
I544 (net01043 net01027) MISModel_AdjacentXtalk
I520 (net0920 net0855) MISModel_AdjacentXtalk
I517 (net0834 net0944) MISModel_AdjacentXtalk
I512 (net0861 net0875) MISModel_AdjacentXtalk
I509 (net0870 net0836) MISModel_AdjacentXtalk
I485 (net0880 net0853) MISModel_AdjacentXtalk
I482 (net0945 net0116) MISModel_AdjacentXtalk
I477 (net0123 net0943) MISModel_AdjacentXtalk
I474 (net0868 net0131) MISModel_AdjacentXtalk
I466 (net0940 net0958) MISModel_AdjacentXtalk
I463 (net0827 net0923) MISModel_AdjacentXtalk
I458 (net0877 net0889) MISModel_AdjacentXtalk
I455 (net0956 net0962) MISModel_AdjacentXtalk
I377 (net0801 net0886) MISModel_AdjacentXtalk
I374 (net0881 net0242) MISModel_AdjacentXtalk
I369 (net0249 net0873) MISModel_AdjacentXtalk
I366 (net0947 net0257) MISModel_AdjacentXtalk
I326 (net0879 net0296) MISModel_AdjacentXtalk
I323 (net0303 net0305) MISModel_AdjacentXtalk
I318 (net0312 net0310) MISModel_AdjacentXtalk
I315 (net0854 net0320) MISModel_AdjacentXtalk
I307 (net0804 net0331) MISModel_AdjacentXtalk
I304 (net0338 net0340) MISModel_AdjacentXtalk
I299 (net0347 net0345) MISModel_AdjacentXtalk
I296 (net0951 net0355) MISModel_AdjacentXtalk
I205 (net0437 net0434) MISModel_AdjacentXtalk
I202 (net033 net0440) MISModel_AdjacentXtalk
I197 (net042 net040) MISModel_AdjacentXtalk
I194 (net0430 net0427) MISModel_AdjacentXtalk
I186 (net03 net0418) MISModel_AdjacentXtalk
I183 (net0451 net070) MISModel_AdjacentXtalk
I178 (net077 net0438) MISModel_AdjacentXtalk
I175 (net0404 net085) MISModel_AdjacentXtalk
I135 (net01 net0445) MISModel_AdjacentXtalk
I132 (net0420 net0161) MISModel_AdjacentXtalk
I127 (net0168 net0166) MISModel_AdjacentXtalk
I124 (net0429 net0176) MISModel_AdjacentXtalk
I116 (net0435 net0187) MISModel_AdjacentXtalk
I113 (net0194 net0196) MISModel_AdjacentXtalk
I108 (net0203 net0201) MISModel_AdjacentXtalk
I105 (net0399 net0211) MISModel_AdjacentXtalk
I61 (net0154 net0138) MISModel_AdjacentXtalk
I58 (net0139 net0147) MISModel_AdjacentXtalk
I53 (net0156 net0160) MISModel_AdjacentXtalk
I50 (net0159 net038) MISModel_AdjacentXtalk
I12 (net013 net011) MISModel_AdjacentXtalk
I7 (net020 net022) MISModel_AdjacentXtalk
I2 (net029 net027) MISModel_AdjacentXtalk
I72 (net35 net33) MISModel_AdjacentXtalk
C399 (net01118 net01110) capacitor c=1p
C398 (net01267 0) capacitor c=2p
C397 (net01217 net01212) capacitor c=1p
C396 (net01309 0) capacitor c=2p
C395 (net01294 net01357) capacitor c=1p
C394 (net01149 net01345) capacitor c=1p
C393 (net01152 0) capacitor c=2p
C392 (net01294 net01136) capacitor c=1p
C391 (net01295 net01322) capacitor c=1p
C390 (net01139 0) capacitor c=2p
C389 (net01334 0) capacitor c=2p
C388 (net01294 net01355) capacitor c=1p
C387 (net01332 net01068) capacitor c=1p
C386 (net01359 0) capacitor c=2p
C385 (net01294 net01255) capacitor c=1p
C384 (net01314 net01202) capacitor c=1p
C383 (net01336 0) capacitor c=2p
C382 (net01191 net01318) capacitor c=1p
C381 (net01231 0) capacitor c=2p
C380 (net01356 net01263) capacitor c=1p
C379 (net01326 0) capacitor c=2p
C378 (net01214 0) capacitor c=2p
C377 (net01350 net01327) capacitor c=1p
C376 (net01329 0) capacitor c=2p
C375 (net01346 net01300) capacitor c=1p
C374 (net01338 0) capacitor c=2p
C373 (net01199 net01232) capacitor c=1p
C372 (net01146 net01351) capacitor c=1p
C371 (net01370 0) capacitor c=2p
C370 (net01236 net01352) capacitor c=1p
C369 (net01146 net01360) capacitor c=1p
C368 (net01316 0) capacitor c=2p
C367 (net01328 0) capacitor c=2p
C366 (net01069 net01331) capacitor c=1p
C365 (net01146 net01315) capacitor c=1p
C364 (net01372 0) capacitor c=2p
C363 (net01366 net01228) capacitor c=1p
C362 (net01146 net01371) capacitor c=1p
C361 (net01108 0) capacitor c=2p
C360 (net01349 net01176) capacitor c=1p
C359 (net01276 0) capacitor c=2p
C358 (net01243 net01354) capacitor c=1p
C357 (net01101 net01190) capacitor c=1p
C356 (net0992 net01175) capacitor c=1p
C355 (net01189 net01049) capacitor c=1p
C354 (net01178 net01102) capacitor c=1p
C353 (net01171 net0977) capacitor c=1p
C352 (net01178 net01016) capacitor c=1p
C351 (net01159 net01172) capacitor c=1p
C350 (net01178 net01002) capacitor c=1p
C349 (net01081 net01164) capacitor c=1p
C348 (net01178 net01107) capacitor c=1p
C347 (net01052 net01153) capacitor c=1p
C346 (net01158 net01041) capacitor c=1p
C345 (net01040 0) capacitor c=1p
C344 (net01012 0) capacitor c=1p
C343 (net01080 0) capacitor c=1p
C342 (net01077 0) capacitor c=1p
C341 (net072 0) capacitor c=1p
C340 (net0998 0) capacitor c=1p
C339 (net01184 0) capacitor c=1p
C338 (net01014 0) capacitor c=1p
C337 (net01034 0) capacitor c=1p
C336 (net01183 0) capacitor c=1p
C335 (net0999 0) capacitor c=1p
C334 (net01157 net01006) capacitor c=1p
C333 (net01167 net01119) capacitor c=1p
C332 (net01167 net01031) capacitor c=1p
C331 (net0966 net01194) capacitor c=1p
C330 (net01192 0) capacitor c=1p
C329 (net01048 0) capacitor c=1p
C328 (net0980 net01078) capacitor c=1p
C327 (net01167 net01131) capacitor c=1p
C326 (net01021 net01027) capacitor c=1p
C325 (net01174 0) capacitor c=1p
C324 (net01167 net01043) capacitor c=1p
C323 (net01053 0) capacitor c=1p
C322 (net01087 net01147) capacitor c=1p
C321 (net01038 0) capacitor c=1p
C320 (net01104 net01186) capacitor c=1p
C319 (net01180 0) capacitor c=1p
C318 (net01044 net01092) capacitor c=1p
C317 (net01111 0) capacitor c=1p
C316 (net0964 net01085) capacitor c=1p
C315 (net0955 0) capacitor c=2p
C314 (net0797 0) capacitor c=2p
C313 (net0882 net0855) capacitor c=1p
C312 (net0802 net0920) capacitor c=1p
C311 (net0802 net0834) capacitor c=1p
C310 (net0824 net0944) capacitor c=1p
C309 (net0818 0) capacitor c=2p
C308 (net0828 0) capacitor c=2p
C307 (net0950 net0875) capacitor c=1p
C306 (net0802 net0861) capacitor c=1p
C305 (net0939 net0836) capacitor c=1p
C304 (net0942 0) capacitor c=2p
C303 (net0802 net0870) capacitor c=1p
C302 (net073 0) capacitor c=2p
C301 (net0826 net0799) capacitor c=1p
C300 (net0829 0) capacitor c=2p
C299 (net0927 net081) capacitor c=1p
C298 (net087 0) capacitor c=2p
C297 (net089 net088) capacitor c=1p
C296 (net0863 0) capacitor c=2p
C295 (net096 net095) capacitor c=1p
C294 (net0924 0) capacitor c=2p
C293 (net0887 0) capacitor c=2p
C292 (net0884 net0853) capacitor c=1p
C291 (net0883 net0880) capacitor c=1p
C290 (net0883 net0945) capacitor c=1p
C289 (net0859 net0116) capacitor c=1p
C288 (net0117 0) capacitor c=2p
C287 (net0931 0) capacitor c=2p
C286 (net0838 net0943) capacitor c=1p
C285 (net0883 net0123) capacitor c=1p
C284 (net0130 net0131) capacitor c=1p
C283 (net0851 0) capacitor c=2p
C282 (net0883 net0868) capacitor c=1p
C281 (net0876 0) capacitor c=2p
C280 (net0806 0) capacitor c=2p
C279 (net0847 net0958) capacitor c=1p
C278 (net0891 net0940) capacitor c=1p
C277 (net0891 net0827) capacitor c=1p
C276 (net0805 net0923) capacitor c=1p
C275 (net0832 0) capacitor c=2p
C274 (net0825 0) capacitor c=2p
C273 (net0809 net0889) capacitor c=1p
C272 (net0891 net0877) capacitor c=1p
C271 (net0915 net0962) capacitor c=1p
C270 (net0795 0) capacitor c=2p
C269 (net0891 net0956) capacitor c=1p
C268 (net0171 0) capacitor c=2p
C267 (net0808 net0172) capacitor c=1p
C266 (net0178 0) capacitor c=2p
C265 (net0180 net0179) capacitor c=1p
C264 (net0185 0) capacitor c=2p
C263 (net0913 net0869) capacitor c=1p
C262 (net0900 0) capacitor c=2p
C261 (net0878 net0894) capacitor c=1p
C260 (net0198 0) capacitor c=2p
C259 (net0901 net0199) capacitor c=1p
C258 (net0206 0) capacitor c=2p
C257 (net0810 net0207) capacitor c=1p
C256 (net0213 0) capacitor c=2p
C255 (net0215 net0214) capacitor c=1p
C254 (net0846 0) capacitor c=2p
C253 (net0222 net0221) capacitor c=1p
C226 (net0902 0) capacitor c=1p
C225 (net0941 0) capacitor c=1p
C224 (net0849 net0886) capacitor c=1p
C223 (net0935 net0801) capacitor c=1p
C222 (net0935 net0881) capacitor c=1p
C221 (net0803 net0242) capacitor c=1p
C220 (net0874 0) capacitor c=1p
C219 (net0246 0) capacitor c=1p
C218 (net0960 net0873) capacitor c=1p
C217 (net0935 net0249) capacitor c=1p
C216 (net0256 net0257) capacitor c=1p
C215 (net0934 0) capacitor c=1p
C214 (net0935 net0947) capacitor c=1p
C213 (net0911 0) capacitor c=1p
C212 (net0264 net0263) capacitor c=1p
C211 (net0821 0) capacitor c=1p
C210 (net0271 net0270) capacitor c=1p
C209 (net0276 0) capacitor c=1p
C208 (net0278 net0277) capacitor c=1p
C207 (net0283 0) capacitor c=1p
C206 (net0285 net0284) capacitor c=1p
C197 (net0290 0) capacitor c=1p
C196 (net0295 0) capacitor c=1p
C195 (net0297 net0296) capacitor c=1p
C194 (net0833 net0879) capacitor c=1p
C193 (net0833 net0303) capacitor c=1p
C192 (net0304 net0305) capacitor c=1p
C191 (net0306 0) capacitor c=1p
C190 (net0309 0) capacitor c=1p
C189 (net0311 net0310) capacitor c=1p
C188 (net0833 net0312) capacitor c=1p
C187 (net0319 net0320) capacitor c=1p
C186 (net0321 0) capacitor c=1p
C185 (net0833 net0854) capacitor c=1p
C184 (net0325 0) capacitor c=1p
C183 (net0330 0) capacitor c=1p
C182 (net0332 net0331) capacitor c=1p
C181 (net0904 net0804) capacitor c=1p
C180 (net0904 net0338) capacitor c=1p
C179 (net0339 net0340) capacitor c=1p
C178 (net0341 0) capacitor c=1p
C177 (net0344 0) capacitor c=1p
C176 (net0346 net0345) capacitor c=1p
C175 (net0904 net0347) capacitor c=1p
C174 (net0354 net0355) capacitor c=1p
C173 (net0356 0) capacitor c=1p
C172 (net0904 net0951) capacitor c=1p
C171 (net0360 0) capacitor c=1p
C170 (net0362 net0361) capacitor c=1p
C169 (net0367 0) capacitor c=1p
C168 (net0369 net0368) capacitor c=1p
C167 (net0374 0) capacitor c=1p
C166 (net0376 net0375) capacitor c=1p
C165 (net0381 0) capacitor c=1p
C164 (net0383 net0382) capacitor c=1p
C163 (net0387 0) capacitor c=1p
C162 (net0389 net0388) capacitor c=1p
C161 (net0395 0) capacitor c=1p
C160 (net0837 net0396) capacitor c=1p
C159 (net0831 0) capacitor c=1p
C158 (net0933 net0948) capacitor c=1p
C157 (net0914 0) capacitor c=1p
C156 (net0925 net0858) capacitor c=1p
C126 (net0417 0) capacitor c=2p
C125 (net025 0) capacitor c=2p
C124 (net0422 net0434) capacitor c=1p
C123 (net0398 net0437) capacitor c=1p
C122 (net0398 net033) capacitor c=1p
C121 (net034 net0440) capacitor c=1p
C120 (net0428 0) capacitor c=2p
C119 (net0444 0) capacitor c=2p
C118 (net041 net040) capacitor c=1p
C117 (net0398 net042) capacitor c=1p
C116 (net049 net0427) capacitor c=1p
C115 (net0449 0) capacitor c=2p
C114 (net0398 net0430) capacitor c=1p
C113 (net055 0) capacitor c=1p
C112 (net0412 0) capacitor c=1p
C111 (net062 net0418) capacitor c=1p
C110 (net0453 net03) capacitor c=1p
C109 (net0453 net0451) capacitor c=1p
C108 (net0416 net070) capacitor c=1p
C107 (net071 0) capacitor c=1p
C106 (net074 0) capacitor c=1p
C105 (net0457 net0438) capacitor c=1p
C104 (net0453 net077) capacitor c=1p
C103 (net084 net085) capacitor c=1p
C102 (net086 0) capacitor c=1p
C101 (net0453 net0404) capacitor c=1p
C100 (net090 0) capacitor c=1p
C99 (net092 net091) capacitor c=1p
C98 (net097 0) capacitor c=1p
C97 (net099 net098) capacitor c=1p
C96 (net0104 0) capacitor c=1p
C95 (net0106 net0105) capacitor c=1p
C94 (net0111 0) capacitor c=1p
C93 (net0113 net0112) capacitor c=1p
C92 (net0118 0) capacitor c=2p
C91 (net0120 net0119) capacitor c=1p
C90 (net0125 0) capacitor c=2p
C89 (net0127 net0126) capacitor c=1p
C88 (net0132 0) capacitor c=2p
C87 (net0447 net0442) capacitor c=1p
C86 (net0406 0) capacitor c=2p
C85 (net0423 net0450) capacitor c=1p
C84 (net0403 0) capacitor c=1p
C83 (net0452 0) capacitor c=1p
C82 (net0455 net0445) capacitor c=1p
C81 (net0411 net01) capacitor c=1p
C80 (net0411 net0420) capacitor c=1p
C79 (net0433 net0161) capacitor c=1p
C78 (net0162 0) capacitor c=1p
C77 (net0165 0) capacitor c=1p
C76 (net0167 net0166) capacitor c=1p
C75 (net0411 net0168) capacitor c=1p
C74 (net0175 net0176) capacitor c=1p
C73 (net0177 0) capacitor c=1p
C72 (net0411 net0429) capacitor c=1p
C71 (net0181 0) capacitor c=1p
C70 (net0186 0) capacitor c=1p
C69 (net0188 net0187) capacitor c=1p
C68 (net0401 net0435) capacitor c=1p
C67 (net0401 net0194) capacitor c=1p
C66 (net0195 net0196) capacitor c=1p
C65 (net0197 0) capacitor c=1p
C64 (net0200 0) capacitor c=1p
C63 (net0202 net0201) capacitor c=1p
C62 (net0401 net0203) capacitor c=1p
C61 (net0210 net0211) capacitor c=1p
C60 (net0212 0) capacitor c=1p
C59 (net0401 net0399) capacitor c=1p
C58 (net0216 0) capacitor c=1p
C57 (net0218 net0217) capacitor c=1p
C56 (net0223 0) capacitor c=1p
C55 (net0225 net0224) capacitor c=1p
C54 (net0230 0) capacitor c=1p
C53 (net0232 net0231) capacitor c=1p
C52 (net0237 0) capacitor c=1p
C51 (net0239 net0238) capacitor c=1p
C50 (net0243 0) capacitor c=1p
C49 (net0245 net0244) capacitor c=1p
C48 (net0251 0) capacitor c=1p
C47 (net0253 net0252) capacitor c=1p
C46 (net0258 0) capacitor c=1p
C45 (net0260 net0259) capacitor c=1p
C44 (net0265 0) capacitor c=1p
C43 (net0267 net0266) capacitor c=1p
C42 (net0135 0) capacitor c=2p
C41 (net0150 0) capacitor c=2p
C40 (net0134 net0138) capacitor c=1p
C39 (net0140 net0154) capacitor c=1p
C38 (net0140 net0139) capacitor c=1p
C37 (net0157 net0147) capacitor c=1p
C36 (net024 0) capacitor c=2p
C35 (net0148 0) capacitor c=2p
C34 (net0141 net0160) capacitor c=1p
C33 (net0140 net0156) capacitor c=1p
C32 (net037 net038) capacitor c=1p
C31 (net039 0) capacitor c=2p
C30 (net0140 net0159) capacitor c=1p
C29 (net043 0) capacitor c=2p
C28 (net045 net044) capacitor c=1p
C27 (net0149 0) capacitor c=2p
C26 (net052 net051) capacitor c=1p
C25 (net057 0) capacitor c=2p
C24 (net059 net0153) capacitor c=1p
C23 (net064 0) capacitor c=2p
C22 (net066 net0151) capacitor c=1p
C21 (net069 0) capacitor c=2p
C20 (net075 net080) capacitor c=1p
C19 (net078 0) capacitor c=2p
C18 (net014 net076) capacitor c=1p
C17 (net061 0) capacitor c=2p
C16 (net068 net058) capacitor c=1p
C15 (net04 0) capacitor c=2p
C14 (net05 net02) capacitor c=1p
C12 (net010 0) capacitor c=2p
C11 (net012 net011) capacitor c=1p
C10 (net1 net013) capacitor c=1p
C6 (net1 net020) capacitor c=1p
C5 (net021 net022) capacitor c=1p
C4 (net023 0) capacitor c=2p
C3 (net026 0) capacitor c=2p
C2 (net028 net027) capacitor c=1p
C1 (net1 net029) capacitor c=1p
C0 (net18 0) capacitor c=2p
C7 (net32 0) capacitor c=2p
C9 (net34 net33) capacitor c=1p
C8 (net1 net35) capacitor c=1p
I663 (net01118 net01347 net01267) MISModel_Aggressor
I659 (net01217 net01200 net01309) MISModel_Aggressor
I655 (net01149 net01342 net01152) MISModel_Aggressor
I650 (net01295 net01070 net01139) MISModel_Aggressor
I648 (net01294 net01343 net01334) MISModel_Aggressor
I644 (net01332 net01299 net01359) MISModel_Aggressor
I640 (net01314 net01187 net01336) MISModel_Aggressor
I636 (net01191 net01182 net01231) MISModel_Aggressor
I632 (net01356 net01216 net01326) MISModel_Aggressor
I629 (net01350 net01249 net01214) MISModel_Aggressor
I625 (net01346 net01165 net01329) MISModel_Aggressor
I621 (net01199 net01114 net01338) MISModel_Aggressor
I617 (net01236 net01365 net01370) MISModel_Aggressor
I613 (net01146 net01333 net01316) MISModel_Aggressor
I611 (net01069 net01137 net01328) MISModel_Aggressor
I606 (net01366 net01271 net01372) MISModel_Aggressor
I602 (net01349 net01203 net01108) MISModel_Aggressor
I598 (net01243 net01240 net01276) MISModel_Aggressor
I586 (net01101 net0963 net01040) MISModel_Aggressor
I583 (net0992 net0979 net01012) MISModel_Aggressor
I580 (net01189 net01059 net01080) MISModel_Aggressor
I577 (net01171 net01173 net01077) MISModel_Aggressor
I574 (net01178 net01160 net072) MISModel_Aggressor
I572 (net01159 net01161 net0998) MISModel_Aggressor
I568 (net01081 net01188 net01184) MISModel_Aggressor
I565 (net01052 net01125 net01014) MISModel_Aggressor
I562 (net01158 net01079 net01034) MISModel_Aggressor
I559 (net01167 net01116 net01183) MISModel_Aggressor
I556 (net01157 net01010 net0999) MISModel_Aggressor
I551 (net0966 net01120 net01192) MISModel_Aggressor
I548 (net0980 net01036 net01048) MISModel_Aggressor
I543 (net01021 net01096 net01174) MISModel_Aggressor
I540 (net01087 net01197 net01053) MISModel_Aggressor
I536 (net01104 net01162 net01038) MISModel_Aggressor
I532 (net01044 net01099 net01180) MISModel_Aggressor
I528 (net0964 net01181 net01111) MISModel_Aggressor
I524 (net0802 net0918 net0955) MISModel_Aggressor
I521 (net0882 net0952 net0797) MISModel_Aggressor
I516 (net0824 net0907 net0818) MISModel_Aggressor
I513 (net0950 net0865 net0828) MISModel_Aggressor
I508 (net0939 net0814 net0942) MISModel_Aggressor
I505 (net0826 net0926 net073) MISModel_Aggressor
I501 (net0927 net0937 net0829) MISModel_Aggressor
I497 (net089 net0916 net087) MISModel_Aggressor
I493 (net096 net0912 net0863) MISModel_Aggressor
I489 (net0883 net0102 net0924) MISModel_Aggressor
I486 (net0884 net0109 net0887) MISModel_Aggressor
I481 (net0859 net0866 net0117) MISModel_Aggressor
I478 (net0838 net0124 net0931) MISModel_Aggressor
I473 (net0130 net0872 net0851) MISModel_Aggressor
I470 (net0891 net0949 net0876) MISModel_Aggressor
I467 (net0847 net0936 net0806) MISModel_Aggressor
I462 (net0805 net0922 net0832) MISModel_Aggressor
I459 (net0809 net0946 net0825) MISModel_Aggressor
I454 (net0915 net0164 net0795) MISModel_Aggressor
I451 (net0808 net0852 net0171) MISModel_Aggressor
I447 (net0180 net0848 net0178) MISModel_Aggressor
I443 (net0913 net0830 net0185) MISModel_Aggressor
I439 (net0878 net0843 net0900) MISModel_Aggressor
I435 (net0901 net0815 net0198) MISModel_Aggressor
I431 (net0810 net0953 net0206) MISModel_Aggressor
I427 (net0215 net0896 net0213) MISModel_Aggressor
I423 (net0222 net0903 net0846) MISModel_Aggressor
I381 (net0935 net0228 net0902) MISModel_Aggressor
I378 (net0849 net0235 net0941) MISModel_Aggressor
I373 (net0803 net0845 net0874) MISModel_Aggressor
I370 (net0960 net0250 net0246) MISModel_Aggressor
I365 (net0256 net0823 net0934) MISModel_Aggressor
I362 (net0264 net0800 net0911) MISModel_Aggressor
I358 (net0271 net0272 net0821) MISModel_Aggressor
I354 (net0278 net0279 net0276) MISModel_Aggressor
I350 (net0285 net0286 net0283) MISModel_Aggressor
I330 (net0833 net0291 net0290) MISModel_Aggressor
I327 (net0297 net0298 net0295) MISModel_Aggressor
I322 (net0304 net0302 net0306) MISModel_Aggressor
I319 (net0311 net0313 net0309) MISModel_Aggressor
I314 (net0319 net0318 net0321) MISModel_Aggressor
I311 (net0904 net0326 net0325) MISModel_Aggressor
I308 (net0332 net0333 net0330) MISModel_Aggressor
I303 (net0339 net0337 net0341) MISModel_Aggressor
I300 (net0346 net0348 net0344) MISModel_Aggressor
I295 (net0354 net0353 net0356) MISModel_Aggressor
I292 (net0362 net0363 net0360) MISModel_Aggressor
I288 (net0369 net0370 net0367) MISModel_Aggressor
I284 (net0376 net0377 net0374) MISModel_Aggressor
I280 (net0383 net0384 net0381) MISModel_Aggressor
I276 (net0389 net0391 net0387) MISModel_Aggressor
I272 (net0837 net0819 net0395) MISModel_Aggressor
I268 (net0933 net0888 net0831) MISModel_Aggressor
I264 (net0925 net0844 net0914) MISModel_Aggressor
I209 (net0398 net0409 net0417) MISModel_Aggressor
I206 (net0422 net0454 net025) MISModel_Aggressor
I201 (net034 net0408 net0428) MISModel_Aggressor
I198 (net041 net0400 net0444) MISModel_Aggressor
I193 (net049 net048 net0449) MISModel_Aggressor
I190 (net0453 net056 net055) MISModel_Aggressor
I187 (net062 net063 net0412) MISModel_Aggressor
I182 (net0416 net0414 net071) MISModel_Aggressor
I179 (net0457 net0456 net074) MISModel_Aggressor
I174 (net084 net083 net086) MISModel_Aggressor
I171 (net092 net093 net090) MISModel_Aggressor
I167 (net099 net0100 net097) MISModel_Aggressor
I163 (net0106 net0107 net0104) MISModel_Aggressor
I159 (net0113 net0114 net0111) MISModel_Aggressor
I155 (net0120 net0121 net0118) MISModel_Aggressor
I151 (net0127 net0128 net0125) MISModel_Aggressor
I147 (net0447 net0426 net0132) MISModel_Aggressor
I143 (net0423 net0443 net0406) MISModel_Aggressor
I139 (net0411 net0402 net0403) MISModel_Aggressor
I136 (net0455 net0410 net0452) MISModel_Aggressor
I131 (net0433 net0439 net0162) MISModel_Aggressor
I128 (net0167 net0169 net0165) MISModel_Aggressor
I123 (net0175 net0174 net0177) MISModel_Aggressor
I120 (net0401 net0182 net0181) MISModel_Aggressor
I117 (net0188 net0189 net0186) MISModel_Aggressor
I112 (net0195 net0193 net0197) MISModel_Aggressor
I109 (net0202 net0204 net0200) MISModel_Aggressor
I104 (net0210 net0209 net0212) MISModel_Aggressor
I101 (net0218 net0219 net0216) MISModel_Aggressor
I97 (net0225 net0226 net0223) MISModel_Aggressor
I93 (net0232 net0233 net0230) MISModel_Aggressor
I89 (net0239 net0240 net0237) MISModel_Aggressor
I85 (net0245 net0247 net0243) MISModel_Aggressor
I81 (net0253 net0254 net0251) MISModel_Aggressor
I77 (net0260 net0261 net0258) MISModel_Aggressor
I73 (net0267 net0268 net0265) MISModel_Aggressor
I65 (net0140 net0137 net0135) MISModel_Aggressor
I62 (net0134 net0152 net0150) MISModel_Aggressor
I57 (net0157 net0144 net024) MISModel_Aggressor
I54 (net0141 net0133 net0148) MISModel_Aggressor
I49 (net037 net036 net039) MISModel_Aggressor
I46 (net045 net046 net043) MISModel_Aggressor
I42 (net052 net053 net0149) MISModel_Aggressor
I38 (net059 net060 net057) MISModel_Aggressor
I34 (net066 net0142 net064) MISModel_Aggressor
I30 (net075 net079 net069) MISModel_Aggressor
I26 (net014 net067 net078) MISModel_Aggressor
I22 (net068 net065 net061) MISModel_Aggressor
I17 (net05 net06 net04) MISModel_Aggressor
I13 (net012 net050 net010) MISModel_Aggressor
I6 (net021 net019 net023) MISModel_Aggressor
I3 (net028 net030 net026) MISModel_Aggressor
I0 (net1 net22 net18) MISModel_Aggressor
I71 (net34 net36 net32) MISModel_Aggressor
I664 (net01357 net01110) MISModel_DiagonalXtalk
I660 (net01357 net01212) MISModel_DiagonalXtalk
I637 (net01255 net01318) MISModel_DiagonalXtalk
I633 (net01255 net01263) MISModel_DiagonalXtalk
I628 (net01351 net01327) MISModel_DiagonalXtalk
I624 (net01351 net01300) MISModel_DiagonalXtalk
I601 (net01371 net01176) MISModel_DiagonalXtalk
I597 (net01371 net01354) MISModel_DiagonalXtalk
I595 (net01102 net01190) MISModel_DiagonalXtalk
I594 (net01102 net01175) MISModel_DiagonalXtalk
I589 (net01107 net01153) MISModel_DiagonalXtalk
I588 (net01107 net01041) MISModel_DiagonalXtalk
I539 (net01119 net01147) MISModel_DiagonalXtalk
I535 (net01043 net01186) MISModel_DiagonalXtalk
I531 (net01043 net01092) MISModel_DiagonalXtalk
I527 (net01119 net01085) MISModel_DiagonalXtalk
I504 (net0920 net0799) MISModel_DiagonalXtalk
I500 (net0870 net081) MISModel_DiagonalXtalk
I496 (net0870 net088) MISModel_DiagonalXtalk
I492 (net0920 net095) MISModel_DiagonalXtalk
I450 (net0940 net0172) MISModel_DiagonalXtalk
I446 (net0956 net0179) MISModel_DiagonalXtalk
I442 (net0956 net0869) MISModel_DiagonalXtalk
I438 (net0940 net0894) MISModel_DiagonalXtalk
I434 (net0880 net0199) MISModel_DiagonalXtalk
I430 (net0868 net0207) MISModel_DiagonalXtalk
I426 (net0868 net0214) MISModel_DiagonalXtalk
I422 (net0880 net0221) MISModel_DiagonalXtalk
I361 (net0801 net0263) MISModel_DiagonalXtalk
I357 (net0947 net0270) MISModel_DiagonalXtalk
I353 (net0947 net0277) MISModel_DiagonalXtalk
I349 (net0801 net0284) MISModel_DiagonalXtalk
I291 (net0804 net0361) MISModel_DiagonalXtalk
I287 (net0951 net0368) MISModel_DiagonalXtalk
I283 (net0951 net0375) MISModel_DiagonalXtalk
I279 (net0804 net0382) MISModel_DiagonalXtalk
I275 (net0879 net0388) MISModel_DiagonalXtalk
I271 (net0854 net0396) MISModel_DiagonalXtalk
I267 (net0854 net0948) MISModel_DiagonalXtalk
I263 (net0879 net0858) MISModel_DiagonalXtalk
I170 (net03 net091) MISModel_DiagonalXtalk
I166 (net0404 net098) MISModel_DiagonalXtalk
I162 (net0404 net0105) MISModel_DiagonalXtalk
I158 (net03 net0112) MISModel_DiagonalXtalk
I154 (net0437 net0119) MISModel_DiagonalXtalk
I150 (net0430 net0126) MISModel_DiagonalXtalk
I146 (net0430 net0442) MISModel_DiagonalXtalk
I142 (net0437 net0450) MISModel_DiagonalXtalk
I100 (net0435 net0217) MISModel_DiagonalXtalk
I96 (net0399 net0224) MISModel_DiagonalXtalk
I92 (net0399 net0231) MISModel_DiagonalXtalk
I88 (net0435 net0238) MISModel_DiagonalXtalk
I84 (net01 net0244) MISModel_DiagonalXtalk
I80 (net0429 net0252) MISModel_DiagonalXtalk
I76 (net0429 net0259) MISModel_DiagonalXtalk
I68 (net01 net0266) MISModel_DiagonalXtalk
I45 (net0154 net044) MISModel_DiagonalXtalk
I41 (net0159 net051) MISModel_DiagonalXtalk
I37 (net0159 net0153) MISModel_DiagonalXtalk
I33 (net0154 net0151) MISModel_DiagonalXtalk
I29 (net35 net080) MISModel_DiagonalXtalk
I25 (net013 net076) MISModel_DiagonalXtalk
I21 (net013 net058) MISModel_DiagonalXtalk
I19 (net35 net02) MISModel_DiagonalXtalk
simulatorOptions options reltol=1e-3 vabstol=1e-6 iabstol=1e-12 temp=27 \
    tnom=27 scalem=1.0 scale=1.0 gmin=1e-12 rforce=1 maxnotes=5 maxwarns=5 \
    digits=5 cols=80 pivrel=1e-3 sensfile="../psf/sens.output" \
    checklimitdest=psf
tran tran stop=10n errpreset=conservative write="spectre.ic" \
    writefinal="spectre.fc" annotate=status maxiters=5
finalTimeOP info what=oppoint where=rawfile
modelParameter info what=models where=rawfile
element info what=inst where=rawfile
outputParameter info what=output where=rawfile
designParamVals info what=parameters where=rawfile
primitives info what=primitives where=rawfile
subckts info what=subckts where=rawfile
saveOptions options save=allpub
