// Design: TransitionSimu_RCDelayModel2013/Test_20230409
simulator lang=spectre
global 0
include "/eda/home/wc/Projects/Virtuoso/TSV_Transition_Simu/TSV_Transition_202304/TSMC-65nm(OA)/PDK_files/tsmcN65/../models/spectre/toplevel.scs" section=tt_lib

// TransitionSimu_RCDelayModel2013/Test_20230409/schematic
R2 (net2 net02) resistor r=50
R1 (net5 net2) resistor r=200m
R0 (net1 net5) resistor r=50
C1 (net02 0) capacitor c=2f
C0 (net1 0) capacitor c=2f
V0 (net1 0) vsource type=pulse val0=0 val1=1 period=2n rise=50p fall=50p
simulatorOptions options temp=27
tran tran stop=10n errpreset=moderate
