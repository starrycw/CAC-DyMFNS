// VerilogA for BER_ahdlLib, Buf_v, veriloga

`include "constants.vams"
`include "disciplines.vams"

module Buf_v;

endmodule
