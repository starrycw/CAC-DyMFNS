// Design: BER_simu/tb_dff
simulator lang=spectre
global 0
include "/root/EDA/BER_simu/tsmc65/tsmcN65/../models/spectre/toplevel.scs" section=tt_lib

// tsmcN65/inv/schematic
subckt inv G Gb IN OUT P Pb
parameters pl=60n pw=200n pf=1 psd=200n psa=175n psb=175n nl=60n nw=200n nf=1 nsd=200n nsa=175n nsb=175n
    PM1 (OUT IN P Pb) pch l=pl w=pw*pf m=1 nf=pf
    NM1 (OUT IN G Gb) nch l=nl w=nw*nf m=1 nf=nf
ends inv

// tsmcN65/pass/schematic
subckt pass A C CB Gb Pb Y
parameters pl=60n pw=200n pf=1 psd=200n psa=175n psb=175n nl=60n nw=200n nf=1 nsd=200n nsa=175n nsb=175n
    M0 (A CB Y Pb) pch l=pl w=pw*pf m=1 nf=pf
    M1 (A C Y Gb) nch l=nl w=nw*nf m=1 nf=nf
ends pass

// BER_simu/dff/schematic
subckt dff D gnd Q vdd clk nQ
    I13 (gnd gnd cn c vdd vdd) inv m=1 pl=60n pw=200n pf=1 psd=200n psa=175n psb=175n nl=60n nw=200n nf=1 nsd=200n nsa=175n nsb=175n
    I9 (gnd gnd Q nQ vdd vdd) inv m=1 pl=60n pw=200n pf=1 psd=200n psa=175n psb=175n nl=60n nw=200n nf=1 nsd=200n nsa=175n nsb=175n
    I8 (gnd gnd net21 Q vdd vdd) inv m=1 pl=60n pw=200n pf=1 psd=200n psa=175n psb=175n nl=60n nw=200n nf=1 nsd=200n nsa=175n nsb=175n
    I5 (gnd gnd net20 net38 vdd vdd) inv m=1 pl=60n pw=200n pf=1 psd=200n psa=175n psb=175n nl=60n nw=200n nf=1 nsd=200n nsa=175n nsb=175n
    I3 (gnd gnd net11 net20 vdd vdd) inv m=1 pl=60n pw=200n pf=1 psd=200n psa=175n psb=175n nl=60n nw=200n nf=1 nsd=200n nsa=175n nsb=175n
    I0 (gnd gnd clk cn vdd vdd) inv m=1 pl=60n pw=200n pf=1 psd=200n psa=175n psb=175n nl=60n nw=200n nf=1 nsd=200n nsa=175n nsb=175n
    I10 (nQ cn c gnd vdd net21) pass m=1 pl=60n pw=200n pf=1 psd=200n psa=175n psb=175n nl=60n nw=200n nf=1 nsd=200n nsa=175n nsb=175n
    I7 (net20 c cn gnd vdd net21) pass m=1 pl=60n pw=200n pf=1 psd=200n psa=175n psb=175n nl=60n nw=200n nf=1 nsd=200n nsa=175n nsb=175n
    I6 (net38 c cn gnd vdd net11) pass m=1 pl=60n pw=200n pf=1 psd=200n psa=175n psb=175n nl=60n nw=200n nf=1 nsd=200n nsa=175n nsb=175n
    I2 (D cn c gnd vdd net11) pass m=1 pl=60n pw=200n pf=1 psd=200n psa=175n psb=175n nl=60n nw=200n nf=1 nsd=200n nsa=175n nsb=175n
ends dff

// BER_simu/tb_dff/schematic
I0 (net3 0 net7 net6 net1 net8) dff
V0 (net6 0) vsource dc=2.5 type=dc
V2 (net3 0) vsource type=pulse val0=0 val1=2.5 period=18n
V1 (net1 0) vsource type=pulse val0=0 val1=2.5 period=10n
simulatorOptions options temp=27
tran tran stop=200n
